Controlled sources: E, F, G, H, linear and POLY
*@ probe v(e1) v(f1) v(g1) v(h1) v(e2) v(f2) i(vsense)
.options reltol=1e-6 vntol=1e-9 abstol=1e-15
VA a 0 DC 0.4 AC 1
VB b 0 DC -0.3
RA a 0 10k
E1 e1 0 a b 4.5
RE1 e1 0 1k
VSENSE a s 0
RS s 0 2k
F1 0 f1 VSENSE 3
RF1 f1 0 1k
G1 0 g1 a 0 2m
RG1 g1 0 5k
H1 h1 0 VSENSE 1.5k
RH1 h1 0 1k
E2 e2 0 POLY(2) a 0 b 0 0.1 1 -0.5 0.3 0.2 -0.4
RE2 e2 0 1k
F2 0 f2 POLY(1) VSENSE 1m 2 300
RF2 f2 0 1k
.op
.dc VA -2 2 0.05
.ac dec 5 1 1meg
.end

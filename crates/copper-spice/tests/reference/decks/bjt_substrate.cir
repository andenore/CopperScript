Substrate junction: vertical NPN and PNP, lateral PNP, over temperature
* Each substrate is driven by its own source (AC 1), so i(vsN) is the
* substrate junction's admittance at that bias. QV is vertical (CJS at the
* internal collector), QL a PNP that ngspice makes lateral by default (CJS at
* the internal base), QPV the same PNP with SUBS=1, QT a vertical NPN measured
* at TNOM = 50 degC. The DC sweep runs the substrate of Q1 into forward bias.
*@ probe i(vs1) i(vs2) i(vs3) i(vs4) i(vc1) i(vc2)
*@ temps -40 27 85
.options reltol=1e-6 vntol=1e-9 abstol=1e-15 chgtol=1e-18
VC1 c1 0 DC 2
VB1 b1 0 DC 0.65
VS1 s1 0 DC -1 AC 1
Q1 c1 b1 0 s1 QV
VC2 c2 0 DC -2
VB2 b2 0 DC -0.65
VS2 s2 0 DC -1 AC 1
Q2 c2 b2 0 s2 QL
VC3 c3 0 DC -2
VB3 b3 0 DC -0.65
VS3 s3 0 DC 0 AC 1
Q3 c3 b3 0 s3 QPV
VC4 c4 0 DC 2
VB4 b4 0 DC 0.65
VS4 s4 0 DC -1 AC 1
Q4 c4 b4 0 s4 QT
.model QV NPN(IS=1e-15 BF=150 RC=20 RB=50 CJS=2p VJS=0.65 MJS=0.4 EG=1.11 XTI=3)
.model QL PNP(IS=1e-15 BF=80 RC=20 RB=50 CJS=2p VJS=0.65 MJS=0.4 EG=1.11 XTI=3)
.model QPV PNP(IS=1e-15 BF=80 RC=20 RB=50 CJS=2p VJS=0.65 MJS=0.4 SUBS=1)
.model QT NPN(IS=1e-15 BF=150 RC=20 RB=50 CJS=2p VJS=0.65 MJS=0.4 CJE=4p CJC=2p VJC=0.7 MJC=0.4 TNOM=50)
.op
.dc VS1 -5 0.6 0.1
.ac dec 10 1meg 1g
.end

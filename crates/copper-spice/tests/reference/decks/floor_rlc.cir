Integration floor: series RLC band-pass on a 1 kHz sine (linear, no harmonics)
*@ probe v(b) v(a)
.options reltol=1e-6 vntol=1e-9 abstol=1e-12 chgtol=1e-16
VS in 0 DC 0 AC 1 SIN(0 1 1k)
R1 in a 100
L1 a b 10m
C1 b 0 220n
RL b 0 10k
.ac lin 1 1k 1k
.tran 2u 5m
.end

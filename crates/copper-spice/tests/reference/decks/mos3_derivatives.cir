MOSFET level 3: DC current around one bias point, for its derivatives
* The AC run gives g_m and g_ds (the drain current per volt of gate and of
* drain drive); the DC sweeps, 10 mV apart around the same bias, give the
* derivatives of the DC current itself (a fourth-order central difference).
*@ probe i(vd1) i(vd2)
.options reltol=1e-6 vntol=1e-9 abstol=1e-12 chgtol=1e-14
VG1 g1 0 DC 1.5 AC 1
VD1 d1 0 DC 2
M1 d1 g1 0 0 N3A L=1.2u W=10u
VG2 g2 0 DC 1.5
VD2 d2 0 DC 2 AC 1
M2 d2 g2 0 0 N3A L=1.2u W=10u
.model N3A NMOS(LEVEL=3 TOX=20n NSUB=1e16 U0=600 VMAX=1.5e5 NFS=1e11 XJ=0.3u LD=0.1u WD=0.2u
+ ETA=0.1 THETA=0.06 KAPPA=0.2 DELTA=0.4 CGSO=0.2n CGDO=0.2n CGBO=0.1n)
.dc VG1 1.48 1.52 0.01
.dc VD2 1.98 2.02 0.01
.ac dec 1 1k 1k
.end

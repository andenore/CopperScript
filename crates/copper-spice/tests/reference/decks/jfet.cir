JFET: N- and P-channel, transfer and output curves, y-parameters, noise, switching
* J1 and J2 are the same biased N-channel device with the AC drive on the
* gate of J1 and on the drain of J2. J3 is a self-biased common-source stage
* for the noise analysis, J4 a switch for the transient, J5 a P-channel device.
*@ probe v(d3) v(d4) i(vg1) i(vd1) i(vg2) i(vd2) i(vg5) i(vd5)
*@ tran-probe v(d3) v(d4) i(vd1)
*@ temps -40 27 85
.options reltol=1e-6 vntol=1e-9 abstol=1e-12 chgtol=1e-14
VG1 g1 0 DC -0.8 AC 1
VD1 d1 0 DC 5
J1 d1 g1 0 JN
VG2 g2 0 DC -0.8
VD2 d2 0 DC 5 AC 1
J2 d2 g2 0 JN
VS3 s3 0 DC 0 AC 1
RG3 s3 g3 100k
RD3 dd d3 2k
RS3 src3 0 500
J3 d3 g3 src3 JN
VDD dd 0 DC 10
VG4 g4 0 DC -3 PULSE(-3 0.3 20n 5n 5n 100n 300n)
RD4 dd d4 1k
J4 d4 g4 0 JN
VG5 g5 0 DC 0.7 AC 1
VD5 d5 0 DC -4
J5 d5 g5 0 JP
.model JN NJF(VTO=-2 BETA=1.3m LAMBDA=0.02 IS=1e-14 N=1.1 RD=10 RS=15 CGS=6p CGD=2.5p
+ PB=0.8 M=0.4 FC=0.5 KF=1e-17 AF=1 TCV=-2.5m BEX=-0.5)
.model JP PJF(VTO=-1.8 BETA=0.6m LAMBDA=0.03 IS=2e-14 RD=20 RS=20 CGS=4p CGD=2p PB=0.7 M=0.35)
.op
.dc VG1 -3 0.5 0.02
.dc VD1 -1 6 0.05
.ac dec 10 1k 10g
.noise v(d3) VS3 dec 10 1 1g
.tran 0.2n 300n
.end

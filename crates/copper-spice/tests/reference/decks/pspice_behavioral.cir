PSpice dialect: VALUE sources with IF, LIMIT, STP, MIN, MAX and .PARAM expressions
* TABLE is not compared here: ngspice rounds its corners (README, PSpice dialect).
*@ dialect pspice
*@ ngbehavior psa
*@ probe v(o1) v(o2) v(o3) v(o6) v(o7)
.options reltol=1e-6 vntol=1e-9 abstol=1e-15
.param GAIN={2*1.5} OFFS={GAIN/10} LIM=1.2
.param KNEE={0.1+0.023}
VIN in 0 DC 0.31 SIN(0 1.5 1meg)
E1 o1 0 VALUE={LIMIT(GAIN*V(in)+OFFS, -LIM, LIM)}
E2 o2 0 VALUE={IF(V(in) > 0.217, V(in)*V(in), -0.5*V(in))}
G3 0 o3 VALUE={1m*STP(V(in)-KNEE)*V(in)}
R3 o3 0 1k
E6 o6 0 VALUE={EXP(-V(in)*V(in))*SQRT(ABS(V(in))+1)-1}
E7 o7 0 VALUE={MAX(V(in), MIN(-0.25, 0.5*V(o1)))}
.op
.dc VIN -1.5 1.5 0.05
.tran 5n 2u
.end

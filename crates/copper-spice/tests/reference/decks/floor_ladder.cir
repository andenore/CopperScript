Integration floor: fifth-order LC ladder low-pass (3 kHz) on a 1 kHz sine
*@ probe v(c) v(a)
.options reltol=1e-6 vntol=1e-9 abstol=1e-12 chgtol=1e-16
VS in 0 DC 0 AC 1 SIN(0 1 1k)
RS in a 1k
C1 a 0 32.8n
L2 a b 85.8m
C3 b 0 106n
L4 b c 85.8m
C5 c 0 32.8n
RL c 0 1k
.ac lin 1 1k 1k
.tran 2u 8m
.end

Flicker and shot noise of a diode for the transient-noise statistics
* A diode fed 50 uA from a current source (its small-signal resistance about
* 520 ohm) with 470 nF across it: the output noise is 1/f below the 1/f
* corner (about 300 Hz) and rolls off above 650 Hz.
*@ probe v(a)
.options reltol=1e-6 vntol=1e-9 abstol=1e-12 chgtol=1e-16
I1 0 a DC 50u AC 1
D1 a 0 DN
C1 a 0 470n
.model DN D(IS=1e-14 KF=2e-13 AF=1)
.op
.noise v(a) I1 dec 20 0.1 1meg
.end
